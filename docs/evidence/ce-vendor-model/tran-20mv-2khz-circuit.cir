* Lab04 CE voltage-divider reference (real ngspice run)
VCC vcc 0 DC 12
R1 vcc base 100k
R2 base 0 22k
VIC vcc rctop DC 0
RC rctop collector 2.2k
RE emitter 0 1k
Cin vs base 10u
Cout collector out 10u
RL out 0 10k
Q1 collector base emitter Q2n3904
.MODEL Q2n3904 npn IS=1.26532e-10 BF=206.302 NF=1.5 VAF=1000 IKF=0.0272221 ISE=2.30771e-09 NE=3.31052 BR=20.6302 NR=2.89609 VAR=9.39809 IKR=0.272221 ISC=2.30771e-09 NC=1.9876 RB=5.8376 IRB=50.3624 RBM=0.634251 RE=0.0001 RC=2.65711 XTB=0.1 XTI=1 EG=1.05 CJE=4.64214e-12 VJE=0.4 MJE=0.256227 TF=4.19578e-10 XTF=0.906167 VTF=8.75418 ITF=0.0105823 CJC=3.76961e-12 VJC=0.4 MJC=0.238109 XCJC=0.8 FC=0.512134 CJS=0 VJS=0.75 MJS=0.5 TR=6.82023e-08 PTF=0 KF=0 AF=1
Vs vs 0 AC 20m SIN(0 20m 2k)
.tran 25u 2.5m 0 25u
.end
