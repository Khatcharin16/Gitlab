* ngspice batch spike: ac + tran
V1 in 0 AC 1 SIN(0 1 1k)
R1 in out 1k
C1 out 0 1u
.ac dec 2 1 10k
.tran 10u 2m 0 10u
.end
